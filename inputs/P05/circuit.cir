P05
V1 IN 0 PULSE(0 9 0 1n 1n 5 10)
R1 X 0 3k
R2 IN X 2k
R3 OUT 0 4k
R4 X OUT 2k
C1 IN X 1.5u
.end
