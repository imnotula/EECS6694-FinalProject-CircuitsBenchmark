P07
V1 IN 0 PULSE(0 8 0 1n 1n 5 10)
R1 IN OUT 4k
R2 X 0 3k
R3 X OUT 2k
R4 IN X 2k
C1 X 0 1.2u
.end
