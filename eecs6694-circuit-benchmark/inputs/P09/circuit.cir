P09
V1 IN 0 PULSE(0 6 0 1n 1n 5 10)
R1 OUT 0 4k
R2 IN X 3k
R3 X OUT 2k
R4 X 0 2k
C1 X 0 1u
.end
